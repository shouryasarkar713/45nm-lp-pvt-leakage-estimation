* PMOS_OFF: single PMOS (every terminal on its own voltage source)
.include 45nm_LP.pm
.options gmin=1e-18 abstol=1e-18 reltol=1e-6 vntol=1e-9
.param Lmin=4.5e-08
M1 d g s b pmos W=3.288402e-07 L={Lmin}
Vd d 0 0.110027953
Vg g 0 1.067712962
Vs s 0 0.2184434417
Vb b 0 1.067712962
.control
set numdgt=15
altermod @pmos[vth0] = -0.6031759138
altermod @pmos[toxe] = 1.987034665e-09
altermod @pmos[ndep] = 2.530809627e+18
altermod @pmos[u0] = 0.02160504466
altermod @pmos[xj] = 1.403445112e-08
set temp = 43.5561
op
print i(vd) i(vg) i(vs) i(vb)
.endc
.end
